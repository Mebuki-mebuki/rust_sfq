.subckt NorPipelined a b clk y
XSPLIT1 clk clk1 clk2 THmitll_SPLIT
XOR2 a b clk1 x THmitll_OR2
XNOT3 x clk2 y THmitll_NOT
.ends
.subckt NorCombinational a b clk y
XSPLIT1 clk clk1 _SPLIT1_q2 THmitll_SPLIT
XOR2 a b clk1 x THmitll_OR2
XBUFF3 _SPLIT1_q2 _BUFF3_q THmitll_BUFF
XBUFF4 _BUFF3_q clk2 THmitll_BUFF
XNOT5 x clk2 y THmitll_NOT
.ends
.subckt SingleCyclePath a clk y
XSPLIT1 a a1 a2 THmitll_SPLIT
XSPLIT2 clk clk1 clk2 THmitll_SPLIT
XDFF3 a1 clk1 x THmitll_DFF
XAND4 x a2 clk2 _AND4_q THmitll_AND2
XJTL5 _AND4_q y THmitll_JTL
.ends
.subckt MultiCyclePath a clk y
XSPLIT1 a a1 a2_start THmitll_SPLIT
XBUFF2 a2_start _BUFF2_q THmitll_BUFF
XBUFF3 _BUFF2_q _BUFF3_q THmitll_BUFF
XBUFF4 _BUFF3_q _BUFF4_q THmitll_BUFF
XBUFF5 _BUFF4_q _BUFF5_q THmitll_BUFF
XBUFF6 _BUFF5_q _BUFF6_q THmitll_BUFF
XBUFF7 _BUFF6_q _BUFF7_q THmitll_BUFF
XBUFF8 _BUFF7_q _BUFF8_q THmitll_BUFF
XBUFF9 _BUFF8_q _BUFF9_q THmitll_BUFF
XBUFF10 _BUFF9_q _BUFF10_q THmitll_BUFF
XBUFF11 _BUFF10_q _BUFF11_q THmitll_BUFF
XBUFF12 _BUFF11_q _BUFF12_q THmitll_BUFF
XBUFF13 _BUFF12_q _BUFF13_q THmitll_BUFF
XBUFF14 _BUFF13_q _BUFF14_q THmitll_BUFF
XBUFF15 _BUFF14_q _BUFF15_q THmitll_BUFF
XBUFF16 _BUFF15_q _BUFF16_q THmitll_BUFF
XBUFF17 _BUFF16_q _BUFF17_q THmitll_BUFF
XBUFF18 _BUFF17_q _BUFF18_q THmitll_BUFF
XBUFF19 _BUFF18_q _BUFF19_q THmitll_BUFF
XBUFF20 _BUFF19_q _BUFF20_q THmitll_BUFF
XBUFF21 _BUFF20_q _BUFF21_q THmitll_BUFF
XBUFF22 _BUFF21_q _BUFF22_q THmitll_BUFF
XBUFF23 _BUFF22_q _BUFF23_q THmitll_BUFF
XBUFF24 _BUFF23_q _BUFF24_q THmitll_BUFF
XBUFF25 _BUFF24_q _BUFF25_q THmitll_BUFF
XBUFF26 _BUFF25_q _BUFF26_q THmitll_BUFF
XBUFF27 _BUFF26_q _BUFF27_q THmitll_BUFF
XBUFF28 _BUFF27_q _BUFF28_q THmitll_BUFF
XBUFF29 _BUFF28_q _BUFF29_q THmitll_BUFF
XBUFF30 _BUFF29_q _BUFF30_q THmitll_BUFF
XBUFF31 _BUFF30_q _BUFF31_q THmitll_BUFF
XBUFF32 _BUFF31_q _BUFF32_q THmitll_BUFF
XBUFF33 _BUFF32_q a2_end THmitll_BUFF
XSPLIT34 clk clk1 clk2 THmitll_SPLIT
XDFF35 a1 clk1 _DFF35_q THmitll_DFF
XBUFF36 _DFF35_q _BUFF36_q THmitll_BUFF
XBUFF37 _BUFF36_q x THmitll_BUFF
XAND38 x a2_end clk2 _AND38_q THmitll_AND2
XJTL39 _AND38_q y THmitll_JTL
.ends
.subckt ClockBetweenData a b clk y
XSPLIT1 clk clk1 _SPLIT1_q2 THmitll_SPLIT
XAND2 a b clk1 x THmitll_AND2
XBUFF3 _SPLIT1_q2 _BUFF3_q THmitll_BUFF
XBUFF4 _BUFF3_q _BUFF4_q THmitll_BUFF
XBUFF5 _BUFF4_q _BUFF5_q THmitll_BUFF
XBUFF6 _BUFF5_q _BUFF6_q THmitll_BUFF
XBUFF7 _BUFF6_q clk2 THmitll_BUFF
XOR8 x y1 clk2 y0 THmitll_OR2
XSPLIT9 y0 y y1 THmitll_SPLIT
.ends
