.include ../../../lib/rsfqlib/spice/all.cir
.include modules.cir

XTOP a b clk y NorCombinational

I1      0       11      pwl(0 0 300p 0 302.5p 827.13u 305p 0 400p 0 402.5p 827.13u 405p 0 )
XDC1    11      12      THmitll_DCSFQ
XJ1     12      a       THmitll_JTL

I2      0       21      pwl(0 0 200p 0 202.5p 827.13u 205p 0 400p 0 402.5p 827.13u 405p 0 )
XDC2    21      22      THmitll_DCSFQ
XJ2     22      b       THmitll_JTL

I3      0       31      pwl(0 0 30p 0 32.5p 827.13u 35p 0 130p 0 132.5p 827.13u 135p 0 230p 0 232.5p 827.13u 235p 0 330p 0 332.5p 827.13u 335p 0 430p 0 432.5p 827.13u 435p 0 530p 0 532.5p 827.13u 535p 0 630p 0 632.5p 827.13u 635p 0 )
XDC3    31      32      THmitll_DCSFQ
XJ3     32      clk     THmitll_JTL

R0      y       0       2

.tran 0.25p 800p 0 0.25p
.print v(a)
.print v(b)
.print v(clk1.XTOP)
.print v(x.XTOP)
.print v(x.XTOP)
.print v(clk2.XTOP)
.print v(y)
.end
