.include ../../../lib/rsfqlib/spice/all.cir
.include modules.cir

XTOP a b cin clk cout s FullAdder

I1      0       11      pwl(0 0 450p 0 452.5p 827.13u 455p 0 550p 0 552.5p 827.13u 555p 0 650p 0 652.5p 827.13u 655p 0 750p 0 752.5p 827.13u 755p 0 )
XDC1    11      12      THmitll_DCSFQ
XJ1     12      cin     THmitll_JTL

I2      0       21      pwl(0 0 250p 0 252.5p 827.13u 255p 0 350p 0 352.5p 827.13u 355p 0 650p 0 652.5p 827.13u 655p 0 750p 0 752.5p 827.13u 755p 0 )
XDC2    21      22      THmitll_DCSFQ
XJ2     22      b       THmitll_JTL

I3      0       31      pwl(0 0 150p 0 152.5p 827.13u 155p 0 350p 0 352.5p 827.13u 355p 0 550p 0 552.5p 827.13u 555p 0 750p 0 752.5p 827.13u 755p 0 )
XDC3    31      32      THmitll_DCSFQ
XJ3     32      a       THmitll_JTL

I4      0       41      pwl(0 0 100p 0 102.5p 827.13u 105p 0 200p 0 202.5p 827.13u 205p 0 300p 0 302.5p 827.13u 305p 0 400p 0 402.5p 827.13u 405p 0 500p 0 502.5p 827.13u 505p 0 600p 0 602.5p 827.13u 605p 0 700p 0 702.5p 827.13u 705p 0 800p 0 802.5p 827.13u 805p 0 900p 0 902.5p 827.13u 905p 0 1000p 0 1002.5p 827.13u 1005p 0 1100p 0 1102.5p 827.13u 1105p 0 )
XDC4    41      42      THmitll_DCSFQ
XJ4     42      clk     THmitll_JTL

R0      cout    0       2
R1      s       0       2

.tran 0.25p 1200p 0 0.25p
.print v(cin)
.print v(b)
.print v(a)
.print v(clk)
.print v(cout)
.print v(s)
.end
